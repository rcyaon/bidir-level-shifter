* Extracted by KLayout with SG13CMOS5L LVS runset on : 01/10/2026 07:47

.SUBCKT invlvw a vdd vdd$1 vss vss|y
M$1 vss a vss|y vss|y sg13_lv_nmos L=0.3u W=0.3u AS=0.102p AD=0.093p PS=1.28u
+ PD=1.22u rfmode=0
M$2 vdd a vss|y vdd$1 sg13_lv_pmos L=0.3u W=0.3u AS=0.102p AD=0.102p PS=1.28u
+ PD=1.28u rfmode=0
.ENDS invlvw
