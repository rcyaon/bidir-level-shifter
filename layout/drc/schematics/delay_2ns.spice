** sch_path: xschem/schematics/delay_2ns.sch
.subckt delay_2ns a y vdd vss
*.PININFO a:B y:B vdd:B vss:B
X1 a net1 vdd vss INVLV
C1 net1 vss 0.35p
X2 net1 net2 vdd vss INVLV
C2 net2 vss 0.35p
X3 net2 net3 vdd vss INVLV
C3 net3 vss 0.35p
X4 net3 y vdd vss INVLV
C4 y vss 0.15p
.ends

* expanding   symbol:  logic_gates/INVLV.sym # of pins=4
** sym_path: xschem/logic_gates/INVLV.sym
** sch_path: xschem/logic_gates/INVLV.sch
.subckt INVLV a y vdd vss
*.PININFO vdd:B vss:B y:B a:B
MMP y a vdd vdd sg13_lv_pmos w=1.0u l=0.13u ng=1
MMN y a vss vss sg13_lv_nmos w=0.5u l=0.13u ng=1
.ends
