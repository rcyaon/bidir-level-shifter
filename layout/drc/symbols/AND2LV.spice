** sch_path: /foss/designs/Designs/bidir-level-shifter/xschem/logic_gates/AND2LV.sch
.subckt AND2LV a b y vdd vss
*.PININFO a:B b:B y:B vdd:B vss:B
X1 a b net1 vdd vss NANDLV
X2 net1 y vdd vss INVLV
.ends

* expanding   symbol:  logic_gates/NANDLV.sym # of pins=5
** sym_path: /foss/designs/Designs/bidir-level-shifter/xschem/logic_gates/NANDLV.sym
** sch_path: /foss/designs/Designs/bidir-level-shifter/xschem/logic_gates/NANDLV.sch
.subckt NANDLV a b y vdd vss
*.PININFO vdd:B vss:B y:B a:B b:B
MMP1 y a vdd vdd sg13_lv_pmos w=1.0u l=0.13u ng=1
MMP2 y b vdd vdd sg13_lv_pmos w=1.0u l=0.13u ng=1
MMN1 y a net1 vss sg13_lv_nmos w=0.8u l=0.13u ng=1
MMN2 net1 b vss vss sg13_lv_nmos w=0.8u l=0.13u ng=1
.ends

* expanding   symbol:  logic_gates/INVLV.sym # of pins=4
** sym_path: /foss/designs/Designs/bidir-level-shifter/xschem/logic_gates/INVLV.sym
** sch_path: /foss/designs/Designs/bidir-level-shifter/xschem/logic_gates/INVLV.sch
.subckt INVLV a y vdd vss
*.PININFO vdd:B vss:B y:B a:B
MMP y a vdd vdd sg13_lv_pmos w=1.0u l=0.13u ng=1
MMN y a vss vss sg13_lv_nmos w=0.5u l=0.13u ng=1
.ends
