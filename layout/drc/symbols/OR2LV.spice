** sch_path: /foss/designs/Designs/bidir-level-shifter/xschem/logic_gates/OR2LV.sch
.subckt OR2LV a b y vdd vss
*.PININFO a:B b:B y:B vdd:B vss:B
X1 a b net1 vdd vss NORLV
X2 net1 y vdd vss INVLV
.ends

* expanding   symbol:  logic_gates/NORLV.sym # of pins=5
** sym_path: /foss/designs/Designs/bidir-level-shifter/xschem/logic_gates/NORLV.sym
** sch_path: /foss/designs/Designs/bidir-level-shifter/xschem/logic_gates/NORLV.sch
.subckt NORLV a b y vdd vss
*.PININFO vdd:B vss:B y:B a:B b:B
MMP1 net1 a vdd vdd sg13_lv_pmos w=2.0u l=0.13u ng=1
MMP2 y b net1 vdd sg13_lv_pmos w=2.0u l=0.13u ng=1
MMN1 y a vss vss sg13_lv_nmos w=0.5u l=0.13u ng=1
MMN2 y b vss vss sg13_lv_nmos w=0.5u l=0.13u ng=1
.ends

* expanding   symbol:  logic_gates/INVLV.sym # of pins=4
** sym_path: /foss/designs/Designs/bidir-level-shifter/xschem/logic_gates/INVLV.sym
** sch_path: /foss/designs/Designs/bidir-level-shifter/xschem/logic_gates/INVLV.sch
.subckt INVLV a y vdd vss
*.PININFO vdd:B vss:B y:B a:B
MMP y a vdd vdd sg13_lv_pmos w=1.0u l=0.13u ng=1
MMN y a vss vss sg13_lv_nmos w=0.5u l=0.13u ng=1
.ends
