** sch_path: /foss/designs/Designs/bidir-level-shifter/xschem/logic_gates/INVLVW.sch
.subckt INVLVW a y vdd vss
*.PININFO vdd:B vss:B y:B a:B
MMP y a vdd vdd sg13_lv_pmos w=0.3u l=0.3u ng=1
MMN y a vss vss sg13_lv_nmos w=0.3u l=0.3u ng=1
.ends
