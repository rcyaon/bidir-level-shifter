** sch_path: /foss/designs/Designs/bidir-level-shifter/xschem/logic_gates/MUXLV.sch
.subckt MUXLV in0 in1 sel out vdd vss
*.PININFO out:B in0:B in1:B sel:B vdd:B vss:B
MMT0N out net1 in0 vss sg13_lv_nmos w=1.0u l=0.13u ng=1
MMT0P out sel in0 vdd sg13_lv_pmos w=2.0u l=0.13u ng=1
MMT1N out sel in1 vss sg13_lv_nmos w=1.0u l=0.13u ng=1
MMT1P out net1 in1 vdd sg13_lv_pmos w=2.0u l=0.13u ng=1
XI net1 sel vdd vss sg13cmos5l_inv_1
.ends

* expanding   symbol:  logic_gates/sg13cmos5l_inv_1.sym # of pins=4
** sym_path: /foss/designs/Designs/bidir-level-shifter/xschem/logic_gates/sg13cmos5l_inv_1.sym
** sch_path: /foss/designs/Designs/bidir-level-shifter/xschem/logic_gates/sg13cmos5l_inv_1.sch
.subckt sg13cmos5l_inv_1 Y A VDD VSS
*.PININFO Y:B A:B VDD:B VSS:B
MMN0 Y A VSS VSS sg13_lv_nmos w=0.74u l=0.13u ng=1
MMP0 Y A VDD VDD sg13_lv_pmos w=1.12u l=0.13u ng=1
.ends
