** sch_path: /foss/designs/Designs/bidir-level-shifter/xschem/logic_gates/INVHV1S.sch
.subckt INVHV1S a y vdd vss
*.PININFO vdd:B vss:B y:B a:B
MMP y a vdd vdd sg13_hv_pmos w=2.0u l=0.45u ng=1
MMN y a vss vss sg13_hv_nmos w=2.0u l=0.45u ng=1
.ends
